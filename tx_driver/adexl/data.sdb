ADE simulation setup
Run mode: Single Run, Sweeps and Corners
Tests:
  serdesmsc:tx_driver:1 (off): serdesmsc/tx_driver/schematic, simulator spectre
    Outputs: VT("/vop_p"); (VT("/vop_p") - VT("/vop_n"))
  serdesmsc:tx_driver:2: serdesmsc/tx_driver/schematic, simulator spectre
