ADE simulation setup
Run mode: Single Run, Sweeps and Corners
Tests:
  serdes:FFE:1: serdes/FFE/schematic, simulator spectre
    Variables: VDD = 1.2
