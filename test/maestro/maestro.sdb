ADE simulation setup
Run mode: Single Run, Sweeps and Corners
Tests:
  serdes:test:1: serdes/test/schematic, simulator spectre
