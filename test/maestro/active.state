ADE simulation setup
Test serdes:test:1: serdes/test/schematic, simulator spectre
  Models: /home/cadence/PDK_CRN65GP_v1.0c_official_IC61_20101010/tsmcN65/../models/spectre/crn65gplus_2d5_lk_v1d0.scs[tt_bip, tt_dio, tt_dio_33, tt_mim, tt_dio_dnw, tt_dio_18, tt_bip_npn, tt_33, tt_rfrtmom, tt_mos_cap_25, tt_18, tt_disres, tt_res, tt_dio_na, tt_rfmos_33, tt_dio_hvt, tt_rfmvar, tt_rfmos_18, tt_na, tt_dio_na33, tt_dio_lvt, tt_rfres_sa, tt_na33, tt_dio_esd, tt_rfmim, tt_dio_25od33, tt_25od33, tt, tt_mos_cap, tt_dio_25, tt_dio_25ud18, tt_25, tt_rfmos, tt_25ud18, tt_dio_na25od33, tt_rfjvar, tt_rfmos_25, tt_rtmom, tt_na25od33, tt_dio_na25, tt_rfres_rpo, tt_hvt, tt_rfind, tt_rfmvar_25, tt_na25, tt_lvt]
  Temperature: 27
  Analysis tran: stop=20n errpreset=conservative
  Output "VT(\"/rxp\")-VT(\"/rxm\")" = (VT("/rxp") - VT("/rxm"))
  Output "VT(\"/single\")" = VT("/single")
  Output "VT(\"/net013\")" = VT("/net013")
  Output "VT(\"/net013\")-VT(\"/bal_n\")" = (VT("/net013") - VT("/bal_n"))
  Output S11 dB20 = db(spm('sp 1 1))
  Output S12 dB20 = db(spm('sp 1 2))
  Output S21 dB20 = db(spm('sp 2 1))
  Output S22 dB20 = db(spm('sp 2 2))
  Output v (/rxp /rxm); ac dB20(V) = db((vfreq('ac "/rxp") - vfreq('ac "/rxm")))
  Output v (/rxp /rxm); ac mag(V) = (vfreq('ac "/rxp") - vfreq('ac "/rxm"))
  Output vinm = VT("/vinm") (unticked)
  Output S11 mag = spm('sp 1 1)
  Output v /vs; tran (V) = vtime('tran "/vs")
  Output v /vin1; tran (V) = vtime('tran "/vin1")
  Output v /vout1; tran (V) = vtime('tran "/vout1")
  Output vinp = VT("/vinp") (unticked)
  Signals: /R0/PLUS (terminal), /R1/PLUS (terminal), /voutp, /voutm, /rxp, /rxm, /net08
Run mode: Single Run, Sweeps and Corners
