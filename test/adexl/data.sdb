ADE simulation setup
Run mode: Single Run, Sweeps and Corners
Tests:
  serdesmsc:test:1: serdesmsc/test/schematic, simulator spectre
    Outputs: (VT("/voutp") - VT("/voutm")); (VT("/rxp") - VT("/rxm")); VT("/Clk"); VT("/datain"); VT("/clk"); (VT("/prep") - VT("/prem"))
